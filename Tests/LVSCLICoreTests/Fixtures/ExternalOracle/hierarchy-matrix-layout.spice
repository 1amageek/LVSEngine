.subckt hierarchy_inv a y vdd vss
M0 y a vss vss sky130_fd_pr__nfet_01v8 w=0.42u l=0.15u
M1 y a vdd vdd sky130_fd_pr__pfet_01v8_hvt w=0.42u l=0.15u
.ends hierarchy_inv

.subckt hierarchy_chain input output vdd vss
X0 input internal0 vdd vss hierarchy_inv
X1 internal0 output vdd vss hierarchy_inv
.ends hierarchy_chain

.subckt hierarchy_repeated input output0 output1 vdd vss
X0 input output0 vdd vss hierarchy_inv
X1 input output1 vdd vss hierarchy_inv
.ends hierarchy_repeated

.subckt hierarchy_pair input output vdd vss
X0 input internal1 vdd vss hierarchy_inv
X1 internal1 output vdd vss hierarchy_inv
.ends hierarchy_pair

.subckt hierarchy_three_level input output vdd vss
X0 input internal2 vdd vss hierarchy_pair
X1 internal2 output vdd vss hierarchy_pair
.ends hierarchy_three_level

.subckt hierarchy_parameterized_cell drain gate source bulk width=0.42u
M0 drain gate source bulk sky130_fd_pr__nfet_01v8 w={width} l=0.15u
.ends hierarchy_parameterized_cell

.subckt hierarchy_parameterized input output vss
X0 output input vss vss hierarchy_parameterized_cell width=0.84u
.ends hierarchy_parameterized
