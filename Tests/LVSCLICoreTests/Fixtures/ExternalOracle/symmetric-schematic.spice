.subckt inv in out vdd vss
M1 out in vdd vdd pmos L=0.15u W=1u
R1 b a 100
C1 y x 1f
.ends inv
