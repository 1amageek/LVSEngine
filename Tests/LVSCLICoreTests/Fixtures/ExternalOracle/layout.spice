.subckt inv in out vdd vss
M1 out in vdd vdd pmos
M2 out in vss vss nmos
.ends inv
