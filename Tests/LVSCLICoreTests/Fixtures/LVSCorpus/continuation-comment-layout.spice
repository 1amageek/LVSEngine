.subckt inv in out vdd vss
M1 out in vdd vdd pmos W=1u $ ignored_layout_parameter=bad
+ L=0.15u // ignored_layout_continuation=bad
M2 out in vss vss nmos W=1u
+ L=0.15u $ ignored_layout_tail=bad
.ends inv
