.param total_w=2u nf=4 unit_w={total_w/nf}
.subckt inv in out vdd vss w={unit_w*nf} l={(0.1u + 0.2u)/2}
M1 out in vdd vdd pmos W={w} L={l}
M2 out in vss vss nmos W=0.5u*2 L={l}
.ends inv
