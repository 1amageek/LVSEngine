.lib "includes/standard-cells.lib" tt
.subckt top in out vdd vss
XU1 in out vdd vss inv w=1000n l=150n
.ends top
