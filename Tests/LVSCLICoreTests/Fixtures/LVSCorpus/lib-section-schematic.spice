.lib "includes/standard-cells.lib" tt
.subckt top in out vdd vss
XU1 in out vdd vss inv
.ends top
