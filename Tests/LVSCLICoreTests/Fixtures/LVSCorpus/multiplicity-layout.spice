.subckt inv in out vdd vss
M1 out in vss vss nmos W=1u L=0.15u M=2
.ends inv
