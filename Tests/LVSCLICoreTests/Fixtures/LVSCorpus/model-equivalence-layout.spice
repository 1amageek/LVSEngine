.subckt inv in out vdd vss
M1 out in vss vss sky130_fd_pr__nfet_01v8 W=1u L=0.15u
.ends inv
