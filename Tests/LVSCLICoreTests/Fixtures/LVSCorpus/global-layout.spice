.subckt top in out vdd vss
X1 in out vdd vss inv_with_ports
.ends top
.subckt inv_with_ports in out vdd vss
M1 out in vdd vdd pmos W=1u L=0.15u
M2 out in vss vss nmos W=1u L=0.15u
.ends inv_with_ports
