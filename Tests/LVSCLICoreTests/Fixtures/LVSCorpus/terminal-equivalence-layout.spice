.subckt clamp in vss
D1 in vss diode area=1
.ends clamp
