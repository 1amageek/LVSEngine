.option scale=1u
.subckt inv in out vdd vss
M1 out in vdd vdd pmos W=2 L=0.15
M2 out in vss vss nmos W=1 L=0.15
.ends inv
