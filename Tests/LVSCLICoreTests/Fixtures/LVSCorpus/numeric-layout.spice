.subckt inv in out vdd vss
M1 out in vdd vdd pmos W=1u L=0.15u
R1 a b 1k
C1 x y 1p
.ends inv
