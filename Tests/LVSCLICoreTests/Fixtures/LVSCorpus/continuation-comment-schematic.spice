.subckt inv in out vdd vss
M1 out in vdd vdd pmos W=1u L=0.15u $ ignored_schematic_parameter=bad
M2 out in vss vss nmos W=1u L=0.15u // ignored_schematic_parameter=bad
.ends inv
