.subckt top d g s b
M1 d g s b pmos W=2u L=0.18u
.ends
